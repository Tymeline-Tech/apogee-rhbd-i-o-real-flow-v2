.subckt TOP_IO IN OUT VDDL VDDH VSS POR_N
XLSU1 IN OUT VDDL VDDH VSS LS_UP
XPOR1 VDDH VSS POR_N por
.ends TOP_IO
