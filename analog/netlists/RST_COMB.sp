.subckt RST_COMB RESET_N POR_N RN VDD VSS
XN RESET_N POR_N rnb VDD VSS RST_COMB_RC_NAND2
XI rnb RN VDD VSS RST_COMB_RC_INV
.ends
