.subckt RST_COMB_RC_INV A Y VDD VSS
MP Y A VDD VDD pch W=1 L=0.5
MN Y A VSS VSS nch W=0.5 L=0.5
.ends
