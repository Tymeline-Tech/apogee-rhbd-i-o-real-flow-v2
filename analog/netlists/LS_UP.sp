.subckt LS_UP IN OUT VDDL VDDH VSS
XI IN INB VDDL VSS LS_UP_LS_IN
XC IN INB OUT VDDH VSS LS_UP_LS_CORE
.ends
