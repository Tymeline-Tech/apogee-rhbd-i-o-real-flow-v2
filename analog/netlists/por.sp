.subckt por VDD VSS POR_N
MS B VDD VSS VSS nch W=0.9 L=4
ML0 VDD VDD B VSS nnat W=1 L=25
MH B VDD h VSS nch W=0.42 L=32
MHS h POR_N VSS VSS nch W=1 L=0.5
MCB VDD B VDD VDD pch W=2 L=2
MP2 POR_N B VDD VDD pch W=2 L=0.5
MN2 POR_N B VSS VSS nnat W=1 L=25
MCO VSS POR_N VSS VSS nch W=4 L=4
.ends
