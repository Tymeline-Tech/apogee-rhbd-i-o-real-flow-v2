* NGSPICE file created from LS_UP_LS_IN.ext - technology: sky130A

.subckt LS_UP_LS_IN VSS INB IN VDDL
X0 VDDL IN INB VDDL sky130_fd_pr__pfet_g5v0d10v5 ad=0.29 pd=2.58 as=0.29 ps=2.58 w=1 l=0.5
X1 VSS IN INB VSS sky130_fd_pr__nfet_g5v0d10v5 ad=0.145 pd=1.58 as=0.145 ps=1.58 w=0.5 l=0.5
.ends
